*** 6T SRAM Cell SNM Measurement Deck
.include D:/Projects/Memory-IC-Design/lib/tsmc018.lib
.options filetype=ascii

* Half cell 1 (Inv 1: In=V1, Out=V2)
Mnmos1 V2_hold V1 gnd gnd CMOSN L=0.18U W=0.63U
Mpmos1 vdd     V1 V2_hold vdd CMOSP L=0.18U W=0.27U

* Half cell 1 during Read (WL=1.8V, BIT=1.8V)
Mnmos1_rd V2_read V1 gnd gnd CMOSN L=0.18U W=0.63U
Mpmos1_rd vdd     V1 V2_read vdd CMOSP L=0.18U W=0.27U
Mnmos_ax  V2_read vdd bit gnd CMOSN L=0.18U W=0.36U

VDDsrc vdd 0 DC 1.8
VGND gnd 0 DC 0
Vbit bit 0 DC 1.8
Vin V1 0 DC 0.9

.DC Vin 0 1.8 0.001
.END
