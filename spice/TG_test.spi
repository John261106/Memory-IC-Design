*** SPICE deck for Column CMOS Transmission Gate (TG) Characterization
*** Cell under test: TG{sch}
*** Sizing: NMOS W=0.36U (4*lambda), PMOS W=0.72U (8*lambda)
*** Local Inverter: NMOS W=0.18U (2*lambda), PMOS W=0.27U (3*lambda)

.include D:\Projects\Memory-IC-Design\lib\tsmc018.lib

*** 1. TRANSMISSION GATE CELL NETLIST (from TG.spi) ***
Mnmos@0 BIT_U  EN     BIT_D  gnd CMOSN L=0.18U W=0.36U
Mnmos@1 BITB_U EN     BITB_D gnd CMOSN L=0.18U W=0.36U
Mnmos@2 net@25 EN     gnd    gnd CMOSN L=0.18U W=0.18U
Mpmos@0 BIT_D  net@25 BIT_U  vdd CMOSP L=0.18U W=0.72U
Mpmos@1 BITB_D net@25 BITB_U vdd CMOSP L=0.18U W=0.72U
Mpmos@3 vdd    EN     net@25 vdd CMOSP L=0.18U W=0.27U

*** 2. DC Power Supplies ***
VDDsrc vdd 0 DC 1.8
VGND   gnd 0 DC 0

*** 3. Realistic Column & Global Bus Parasitic Capacitances ***
* Upper bitlines: 16-cell SRAM column load (35fF)
C_BL   BIT_U  gnd 35f
C_BLB  BITB_U gnd 35f

* Down bitlines: Global data bus + sense amp / write driver load (15fF)
C_DL   BIT_D  gnd 15f
C_DLB  BITB_D gnd 15f

* High-impedance bleeder resistors to prevent floating node warnings
R_bleed1 BIT_D  0 100MEG
R_bleed2 BITB_D 0 100MEG

*** 4. Stimulus Signals ***

* Column Enable Pulse from Decoder (EN)
* - 0 to 1ns: Disabled (EN = 0V)
* - 1ns to 4ns: READ Access (EN = 1.8V)
* - 4ns to 5ns: Disabled (EN = 0V)
* - 5ns to 8ns: WRITE Access (EN = 1.8V)
VEN EN 0 PWL(0n 0  0.98n 0  1.0n 1.8  4.0n 1.8  4.02n 0  4.98n 0  5.0n 1.8  8.0n 1.8)

* Upper Bitline Signals during Read (simulating cell developing 150mV differential)
* BIT_U stays at precharged 1.8V
* BITB_U discharges from 1.8V to 1.65V (150mV delta)
V_BIT_U  BIT_U_src  0 DC 1.8
R_BIT_U  BIT_U_src  BIT_U  500
V_BITB_U BITB_U_src 0 PWL(0n 1.8  1.0n 1.8  1.5n 1.65  4.0n 1.65  4.1n 1.8  8.0n 1.8)
R_BITB_U BITB_U_src BITB_U 500

* Write Driver on Down Bitline (BIT_D)
* - Inactive (1.8V via 50k resistor) during read
* - Actively drives BIT_D to 0V at t = 5.2ns during write
V_WRITE   WRITE_src 0 PWL(0n 1.8  5.18n 1.8  5.2n 0  8.0n 0)
R_WRITE   WRITE_src BIT_D PWL(0n 50k  5.18n 50k  5.19n 100  8.0n 100)

*** 5. Automated Performance Measurements for Report ***

* 1. Local Inverter Propagation Delay (Time from EN=0.9V to net@25=0.9V)
.MEAS TRAN t_inv_delay TRIG V(EN) VAL=0.9 RISE=1 TARG V(net@25) VAL=0.9 FALL=1

* 2. Read Differential on Upper Bitlines at t = 3.0ns
.MEAS TRAN V_diff_upper PARAM = (V(BIT_U) - V(BITB_U)) AT=3.0n

* 3. Read Differential Transferred to Global Bus at t = 3.0ns
.MEAS TRAN V_diff_transferred PARAM = (V(BIT_D) - V(BITB_D)) AT=3.0n

* 4. Read Transfer Signal Attenuation (Ratio of transferred to original differential; must be > 98%)
.MEAS TRAN Transfer_Ratio PARAM = (V_diff_transferred / V_diff_upper)

* 5. Write 0 Pull-Down Delay (Time from Write Driver falling to column BIT_U falling below 0.3V)
.MEAS TRAN t_write_transfer TRIG V(BIT_D) VAL=0.9 FALL=1 TARG V(BIT_U) VAL=0.3 FALL=1

*** 6. Transient Simulation ***
.TRAN 10p 8n
.END
