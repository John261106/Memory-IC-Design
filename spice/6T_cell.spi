*** SPICE deck for cell 6T_cell{sch} from library Memory-IC-Design
*** Created on Mon Oct 19, 2026 22:46:02
*** Last revised on Fri Oct 30, 2026 19:05:44
*** Written on Fri Oct 30, 2026 19:13:06 by Electric VLSI Design System, version 9.08
*** Layout tech: mocmos, foundry MOSIS
*** UC SPICE *** , MIN_RESIST 4.0, MIN_CAPAC 0.1FF
* Model cards described in this file:
.include D:\Projects\Memory-IC-Design\lib\tsmc018.lib

*** TOP LEVEL CELL: 6T_cell{sch}
Mnmos@0 net@15 net@21 gnd gnd CMOSN L=0.18U W=0.63U
Mnmos@1 net@21 net@15 gnd gnd CMOSN L=0.18U W=0.63U
Mnmos@2 net@15 WL BIT gnd CMOSN L=0.18U W=0.36U
Mnmos@3 BITB WL net@21 gnd CMOSN L=0.18U W=0.36U
Mpmos@0 vdd net@21 net@15 vdd CMOSP L=0.18U W=0.27U
Mpmos@1 vdd net@15 net@21 vdd CMOSP L=0.18U W=0.27U
.END
