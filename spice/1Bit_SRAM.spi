*** SPICE deck for cell 1Bit_SRAM{sch} from library Memory-IC-Design
*** Created on Tue Oct 20, 2026 23:41:17
*** Last revised on Mon Oct 26, 2026 09:12:33
*** Written on Mon Oct 26, 2026 11:42:25 by Electric VLSI Design System, version 9.08
*** Layout tech: mocmos, foundry MOSIS
*** UC SPICE *** , MIN_RESIST 4.0, MIN_CAPAC 0.1FF
* Model cards described in this file:
.include D:\Projects\Memory-IC-Design\lib\tsmc018.lib

*** SUBCIRCUIT Memory-IC-Design__6T_cell FROM CELL 6T_cell{sch}
.SUBCKT Memory-IC-Design__6T_cell BIT BITB gnd vdd WL
Mnmos@0 net@15 net@21 gnd gnd CMOSN L=0.18U W=0.36U
Mnmos@1 net@21 net@15 gnd gnd CMOSN L=0.18U W=0.36U
Mnmos@2 net@15 WL BIT gnd CMOSN L=0.18U W=0.27U
Mnmos@3 BITB WL net@21 gnd CMOSN L=0.18U W=0.27U
Mpmos@0 vdd net@21 net@15 vdd CMOSP L=0.18U W=0.18U
Mpmos@1 vdd net@15 net@21 vdd CMOSP L=0.18U W=0.18U
.ENDS Memory-IC-Design__6T_cell

*** SUBCIRCUIT Memory-IC-Design__Precharge_ckt FROM CELL Precharge_ckt{sch}
.SUBCKT Memory-IC-Design__Precharge_ckt BIT BITB PCB vdd
Mpmos@0 vdd PCB BIT vdd CMOSP L=0.18U W=0.36U
Mpmos@1 vdd PCB BITB vdd CMOSP L=0.18U W=0.36U
Mpmos@2 BITB PCB BIT vdd CMOSP L=0.18U W=0.18U
.ENDS Memory-IC-Design__Precharge_ckt

*** SUBCIRCUIT Memory-IC-Design__Sense_amp FROM CELL Sense_amp{sch}
.SUBCKT Memory-IC-Design__Sense_amp BIT BITB gnd READ_EN SENSE vdd
Mnmos@3 net@38 BIT net@76 gnd CMOSN L=0.18U W=0.18U
Mnmos@4 net@66 BITB net@38 gnd CMOSN L=0.18U W=0.18U
Mnmos@5 net@38 READ_EN gnd gnd CMOSN L=0.18U W=0.18U
Mnmos@6 SENSE net@66 gnd gnd CMOSN L=0.18U W=0.18U
Mpmos@4 net@76 net@76 vdd vdd CMOSP L=0.18U W=0.18U
Mpmos@5 vdd net@76 net@66 vdd CMOSP L=0.18U W=0.18U
Mpmos@6 vdd net@66 SENSE vdd CMOSP L=0.18U W=0.18U
.ENDS Memory-IC-Design__Sense_amp

*** SUBCIRCUIT Memory-IC-Design__Write_driver FROM CELL Write_driver{sch}
.SUBCKT Memory-IC-Design__Write_driver BIT BITB DATA gnd vdd WRITE_EN
Mnmos@0 BIT WRITE_EN net@6 gnd CMOSN L=0.18U W=0.36U
Mnmos@4 net@6 DATA gnd gnd CMOSN L=0.18U W=0.36U
Mnmos@5 BITB WRITE_EN net@12 gnd CMOSN L=0.18U W=0.36U
Mnmos@6 net@12 net@66 gnd gnd CMOSN L=0.18U W=0.36U
Mnmos@7 gnd DATA net@66 gnd CMOSN L=0.18U W=0.18U
Mpmos@2 net@66 DATA vdd vdd CMOSP L=0.18U W=0.36U
.ENDS Memory-IC-Design__Write_driver

*** TOP LEVEL CELL: 1Bit_SRAM{sch}
X_6T_cell@1 BIT BITB GND VDD WL Memory-IC-Design__6T_cell
XPrecharg@1 BIT BITB PCB VDD Memory-IC-Design__Precharge_ckt
XSense_am@1 BIT BITB GND READ_EN SENSE VDD Memory-IC-Design__Sense_amp
XWrite_dr@1 BIT BITB DATA GND VDD WRITE_EN Memory-IC-Design__Write_driver

* Spice Code nodes in cell cell '1Bit_SRAM{sch}'
VDDsrc VDD 0 DC 1.8
VGND GND 0 DC 0
VPCB PCB 0 PWL(0n 0 5n 0 5.01n 1.8 15n 1.8 15.01n 0 20n 0 20.01n 1.8 30n 1.8 30.01n 0 35n 0 35.01n 1.8 45n 1.8 45.01n 0 50n 0 50.01n 1.8 60n 1.8 60.01n 0 65n 0 65.01n 1.8 75n 1.8 75.01n 0 80n 0 80.01n 1.8 90n 1.8 90.01n 1.8 100n 1.8)
VWL WL 0 PWL(0n 0 5.01n 0 5.02n 1.8 15n 1.8 15.01n 0 20.01n 0 20.02n 1.8 30n 1.8 30.01n 0 35.01n 0 35.02n 1.8 45n 1.8 45.01n 0 50.01n 0 50.02n 1.8 60n 1.8 60.01n 0 65.01n 0 65.02n 1.8 75n 1.8 75.01n 0 80.01n 0 80.02n 1.8 90n 1.8 90.01n 0 100n 0)
VWRITE WRITE_EN 0 PWL(0n 0 5.02n 0 5.03n 1.8 15n 1.8 15.01n 0 65.02n 0 65.03n 1.8 75n 1.8 75.01n 0 100n 0)
VDATA DATA 0 PWL(0n 1.8 35n 1.8 35.01n 0 100n 0)
VREAD READ_EN 0 PWL(0n 0 20.02n 0 20.03n 1.8 30n 1.8 30.01n 0 50.02n 0 50.03n 1.8 60n 1.8 60.01n 0 80.02n 0 80.03n 1.8 90n 1.8 90.01n 0 100n 0)
CBIT BIT GND 5f
CBITB BITB GND 5f
CSENSE SENSE GND 2f
.TRAN 10p 100n
.END
