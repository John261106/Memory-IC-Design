*** SPICE deck for cell Sense_amp{sch} from library Memory-IC-Design
*** Created on Tue Oct 20, 2026 16:32:11
*** Last revised on Thu Oct 22, 2026 20:00:39
*** Written on Sat Oct 31, 2026 12:03:32 by Electric VLSI Design System, version 9.08
*** Layout tech: mocmos, foundry MOSIS
*** UC SPICE *** , MIN_RESIST 4.0, MIN_CAPAC 0.1FF
* Model cards described in this file:
.include D:\Projects\Memory-IC-Design\lib\tsmc018.lib

*** TOP LEVEL CELL: Sense_amp{sch}
Mnmos@3 net@38 BIT net@76 gnd CMOSN L=0.18U W=0.18U
Mnmos@4 net@66 BITB net@38 gnd CMOSN L=0.18U W=0.18U
Mnmos@5 net@38 READ_EN gnd gnd CMOSN L=0.18U W=0.18U
Mnmos@6 SENSE net@66 gnd gnd CMOSN L=0.18U W=0.18U
Mpmos@4 net@76 net@76 vdd vdd CMOSP L=0.18U W=0.18U
Mpmos@5 vdd net@76 net@66 vdd CMOSP L=0.18U W=0.18U
Mpmos@6 vdd net@66 SENSE vdd CMOSP L=0.18U W=0.18U
.END
