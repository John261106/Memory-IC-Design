*** SPICE deck for Current-Mirror Differential Sense Amplifier Characterization
*** Cell under test: Sense_amp{sch}
*** Architecture: 2-Stage OTA (Differential Input + Current Mirror Load + Inverter Buffer)
*** Nodes:
*** - Inputs: BIT, BITB (connected to gates of differential pair)
*** - Control: READ_EN (gate of tail current NMOS)
*** - Output: SENSE (output of second-stage inverter)
*** - Internal: net@38 (tail node), net@76 (mirror reference), net@66 (first stage output)

.include D:\Projects\Memory-IC-Design\lib\tsmc018.lib

*** 1. SENSE AMPLIFIER NETLIST (from Sense_amp.spi) ***
* First Stage: Differential Pair with Current Mirror Load
Mnmos@5 net@38   READ_EN gnd    gnd CMOSN L=0.18U W=0.36U
Mnmos@3 net@38   BIT     net@76 gnd CMOSN L=0.18U W=0.36U
Mnmos@4 net@66   BITB    net@38 gnd CMOSN L=0.18U W=0.36U
Mpmos@4 net@76   net@76  vdd    vdd CMOSP L=0.18U W=0.36U
Mpmos@5 vdd      net@76  net@66 vdd CMOSP L=0.18U W=0.36U

* Second Stage: Output Inverter Buffer
Mnmos@6 SENSE    net@66  gnd    gnd CMOSN L=0.18U W=0.18U
Mpmos@6 vdd      net@66  SENSE  vdd CMOSP L=0.18U W=0.36U

*** 2. Power Supplies ***
VDDsrc vdd 0 DC 1.8
VGND   gnd 0 DC 0

*** 3. Realistic Bitline & Output Capacitances ***
* Bitline parasitic column load (35fF)
CBL  BIT  gnd 35f
CBLB BITB gnd 35f

* Output load (representing output latch / pad input: 15fF)
CLOAD SENSE gnd 15f

*** 4. Differential Sweep Stimulus (dV = V(BIT) - V(BITB)) ***
.PARAM dV = 0
.STEP PARAM dV -150m 150m 10m

* Keeps both bitlines <= 1.8V while sweeping dV from -150mV to +150mV
VBIT  BIT  0 PWL(0n 1.8  0.5n 1.8  1.0n {1.725 + dV/2}  5.0n {1.725 + dV/2})
VBITB BITB 0 PWL(0n 1.8  0.5n 1.8  1.0n {1.725 - dV/2}  5.0n {1.725 - dV/2})

* Single READ_EN strobe from 2.0ns to 4.5ns
VREAD READ_EN 0 PULSE(0 1.8 2.0n 20p 20p 2.5n 10n)

*** 5. Measurements ***
.MEAS TRAN V_out_final FIND V(SENSE) AT=4.0n
.MEAS TRAN t_sense TRIG V(READ_EN) VAL=0.9 RISE=1 TARG V(SENSE) VAL=1.62 RISE=1

*** 6. Transient Simulation ***
.TRAN 10p 5n
.END
