*** 6T SRAM Cell SNM Measurement Deck
.include D:/Projects/Memory-IC-Design/lib/tsmc018.lib

* Hold half-cell
Mnmos1 V2_hold V1 gnd gnd CMOSN L=0.18U W=0.63U
Mpmos1 vdd     V1 V2_hold vdd CMOSP L=0.18U W=0.27U

* Read half-cell (WL=1.8V, BIT=1.8V)
Mnmos1_rd V2_read V1 gnd gnd CMOSN L=0.18U W=0.63U
Mpmos1_rd vdd     V1 V2_read vdd CMOSP L=0.18U W=0.27U
Mnmos_ax  V2_read vdd bit gnd CMOSN L=0.18U W=0.36U

VDDsrc vdd 0 DC 1.8
VGND gnd 0 DC 0
Vbit bit 0 DC 1.8
Vin V1 0 DC 0.9

.DC Vin 0 1.8 0.0005

* Hold VTC Unity Gain Points: dV2_hold / dVin = -1
.MEAS DC V_IL_hold WHEN D(V(V2_hold)) = -1 RISE=1
.MEAS DC V_IH_hold WHEN D(V(V2_hold)) = -1 FALL=1
.MEAS DC V_OL_hold FIND V(V2_hold) AT=1.8
.MEAS DC V_OH_hold FIND V(V2_hold) AT=0.0

* Read VTC Unity Gain Points: dV2_read / dVin = -1
.MEAS DC V_IL_read WHEN D(V(V2_read)) = -1 RISE=1
.MEAS DC V_IH_read WHEN D(V(V2_read)) = -1 FALL=1
.MEAS DC V_OL_read FIND V(V2_read) AT=1.8
.MEAS DC V_OH_read FIND V(V2_read) AT=0.0

.END
