*** SPICE deck for cell Control_logic{sch} from library Memory-IC-Design
*** Architecture: Inverted-Phase 8-Cycle Multi-Strobe Timing & Control Logic Unit
*** Technology: TSMC 0.18um CMOS, VDD = 1.8V
*** Lambda rules: 180nm = 2*lambda -> lambda = 90nm
***
*** Inputs:  CLK, CTRL, COUNT_7, VDD, GND
*** Outputs: PCB, WL_EN, WRITE_EN, READ_EN
***
*** Equations (Cycle = Rising Edge to Rising Edge: High Phase = Precharge, Low Phase = Evaluate):
***   PCB      = ~CLK (0V active precharge during CLK=1 first half; 1.8V off during CLK=0 second half)
***   WL_EN    = COUNT_7 & ~CLK (1.8V wordline enable during CLK=0 second half of 8th cycle)
***   WRITE_EN = ~CTRL & WL_EN  (1.8V write driver enable during CLK=0 second half of 8th cycle when CTRL=0)
***   READ_EN  = CTRL & WL_EN   (1.8V sense amp enable during CLK=0 second half of 8th cycle when CTRL=1)

.include D:\Projects\Memory-IC-Design\lib\tsmc018.lib

*** TOP LEVEL CELL: Control_logic{sch}

* 1. CLK Inverter & PCB 3-Stage Inverting Buffer: CLK -> CLKB -> CLK_buf -> PCB (~CLK)
Mnmos@0 CLKB CLK gnd gnd CMOSN L=0.18U W=0.36U
Mpmos@0 vdd  CLK CLKB vdd CMOSP L=0.18U W=0.72U

Mnmos@2 CLK_buf CLKB gnd gnd CMOSN L=0.18U W=0.36U
Mpmos@2 vdd     CLKB CLK_buf vdd CMOSP L=0.18U W=0.72U

Mnmos@3 PCB CLK_buf gnd gnd CMOSN L=0.18U W=0.54U
Mpmos@3 vdd CLK_buf PCB vdd CMOSP L=0.18U W=1.08U

* 2. CTRL Inverter: CTRL -> CTRLB
Mnmos@4 CTRLB CTRL gnd gnd CMOSN L=0.18U W=0.36U
Mpmos@4 vdd   CTRL CTRLB vdd CMOSP L=0.18U W=0.72U

* 3. WL_EN Block: AND2(COUNT_7, CLKB) -> WL_EN
Mpmos@11 vdd     COUNT_7 WL_ENB vdd CMOSP L=0.18U W=0.36U
Mpmos@12 vdd     CLKB    WL_ENB vdd CMOSP L=0.18U W=0.36U
Mnmos@11 WL_ENB  COUNT_7 net@s1 gnd CMOSN L=0.18U W=0.36U
Mnmos@12 net@s1  CLKB    gnd    gnd CMOSN L=0.18U W=0.36U

Mnmos@13 WL_EN WL_ENB gnd   gnd CMOSN L=0.18U W=0.54U
Mpmos@13 vdd   WL_ENB WL_EN vdd CMOSP L=0.18U W=1.08U

* 4. WRITE_EN Block: AND2(CTRLB, WL_EN) -> WRITE_EN
Mpmos@5 vdd        CTRLB WRITE_ENB vdd CMOSP L=0.18U W=0.36U
Mpmos@6 vdd        WL_EN WRITE_ENB vdd CMOSP L=0.18U W=0.36U
Mnmos@5 WRITE_ENB  CTRLB net@w1    gnd CMOSN L=0.18U W=0.36U
Mnmos@6 net@w1     WL_EN gnd       gnd CMOSN L=0.18U W=0.36U

Mnmos@7 WRITE_EN WRITE_ENB gnd      gnd CMOSN L=0.18U W=0.54U
Mpmos@7 vdd      WRITE_ENB WRITE_EN vdd CMOSP L=0.18U W=1.08U

* 5. READ_EN Block: AND2(CTRL, WL_EN) -> READ_EN
Mpmos@8 vdd       CTRL  READ_ENB vdd CMOSP L=0.18U W=0.36U
Mpmos@9 vdd       WL_EN READ_ENB vdd CMOSP L=0.18U W=0.36U
Mnmos@8 READ_ENB  CTRL  net@r1   gnd CMOSN L=0.18U W=0.36U
Mnmos@9 net@r1    WL_EN gnd      gnd CMOSN L=0.18U W=0.36U

Mnmos@10 READ_EN READ_ENB gnd     gnd CMOSN L=0.18U W=0.54U
Mpmos@10 vdd     READ_ENB READ_EN vdd CMOSP L=0.18U W=1.08U

.END
